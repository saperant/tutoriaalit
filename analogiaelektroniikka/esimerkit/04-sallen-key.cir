* Sallen-Key-alipäästö, vahvistus 1, Butterworth (Q = 0,707), fc = 1 kHz.
* C1 on takaisinkytkentäkondensaattori, C2 maahan.
.include operaatiovahvistimet.lib
.param R=11.254k C2=10n C1=20n
Vp vcc 0 DC 12
Vn vee 0 DC -12
Vin in 0 DC 0 AC 1
R1 in a {R}
R2 a b {R}
C1 a out {C1}
C2 b 0 {C2}
X1 b out out vcc vee OPAMP AOL=1e5 GBW=10Meg
.control
ac dec 100 10 100k
meas ac f3 WHEN vdb(out)=-3.0103 FALL=1
meas ac g100 FIND vdb(out) AT=100
meas ac g1k FIND vdb(out) AT=1k
meas ac g10k FIND vdb(out) AT=10k
meas ac v1k FIND vp(out) AT=1k
wrdata sk.dat vdb(out)
.endc
.end
