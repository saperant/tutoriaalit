* Todellisen operaatiovahvistimen rajat neljänä erillisenä kytkentänä:
* lähdön jännitealue (perinteinen ja rail-to-rail, +-5 V),
* nousunopeus (askel seuraajaan) ja tulon offsetjännite (vahvistus 101).
.include operaatiovahvistimet.lib
Vp5 p5 0 DC 5
Vn5 n5 0 DC -5
Vp vcc 0 DC 12
Vn vee 0 DC -12
* 1) ja 2): vahvistus -10, tulo 0,6 V, ihanteellinen lähtö -6 V.
Vin1 in1 0 DC 0.6
R11 in1 a1 10k
R12 a1 o1 100k
X1 0 a1 o1 p5 n5 OPAMP MARG=1.5
R21 in1 a2 10k
R22 a2 o2 100k
X2 0 a2 o2 p5 n5 OPAMP MARG=0.05
* 3): seuraaja, tuloaskel 0 -> 8 V, nousunopeus 0,5 V/us.
Vin3 in3 0 PULSE(0 8 1u 1n 1n 50u 100u)
X3 in3 o3 o3 vcc vee OPAMP SR=0.5e6
* 4): tulo maassa, offset 2 mV, vahvistus 1 + 100k/1k.
X4 0 a4 o4 vcc vee OPAMP VOS=2m
R41 a4 0 1k
R42 a4 o4 100k
.control
op
print v(o1) v(o2) v(o4)
tran 10n 30u
meas tran t_nousu TRIG v(o3) VAL=0.8 RISE=1 TARG v(o3) VAL=7.2 RISE=1
.endc
.end
