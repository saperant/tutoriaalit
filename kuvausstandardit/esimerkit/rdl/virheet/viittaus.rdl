// Tahallaan virheellinen kuvaus: viittaus olemattomaan rekisteriin.
// Tallainen virhe on kohtalokas (fatal): kaannos pysahtyy heti.
addrmap viittaus {
    reg {
        field { sw = rw; hw = na; hwset; onwrite = woclr; intr; } TILA[0:0];
    } STATUS @ 0x0;
    STATUS.TILA->enable = SALLI.TILA;
};
