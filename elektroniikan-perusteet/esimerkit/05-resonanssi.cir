* Sarja-RLC-piiri: jännite mitataan vastuksen yli (kaistanpäästö).
* L = 1 mH, C = 10 nF, R = 50 ohm: f0 noin 50 kHz.
V1 sisaan 0 DC 0 AC 1
L1 sisaan a 1m
C1 a ulos 10n
R1 ulos 0 50
.control
ac dec 400 1k 1Meg
meas ac f0 WHEN vp(ulos)=0 CROSS=1
meas ac fa WHEN vdb(ulos)=-3.0103 RISE=1
meas ac fy WHEN vdb(ulos)=-3.0103 FALL=1
let kaista = fy - fa
print kaista
.endc
.end
