* CMOS-invertteri: siirtokäyrä (DC) ja viive (transientti).
* U_DD = 1,8 V, kuorma 20 fF (seuraavan portin tulo ja johdotus).
.include transistorit.lib
.param Wp=2.5u
Vdd vdd 0 DC 1.8
Vin sisaan 0 DC 0 PULSE(0 1.8 1n 20p 20p 2n 4n)
Mp ulos sisaan vdd vdd PCMOS W={Wp} L=0.18u
Mn ulos sisaan 0 0 NCMOS W=1u L=0.18u
Ckuorma ulos 0 20f
.control
dc Vin 0 1.8 0.002
meas dc vm WHEN v(ulos)=v(sisaan)
wrdata cmos.dat v(ulos)
tran 1p 6n
meas tran tphl TRIG v(sisaan) VAL=0.9 RISE=1 TARG v(ulos) VAL=0.9 FALL=1
meas tran tplh TRIG v(sisaan) VAL=0.9 FALL=1 TARG v(ulos) VAL=0.9 RISE=1
.endc
.end
